ADE simulation setup
Run mode: Single Run, Sweeps and Corners
Tests:
  EE501_Project1:BGCS_ti:1: ?/?/?, simulator spectre
