ADE simulation setup
Run mode: Single Run, Sweeps and Corners
Tests:
  EE501_Project1:BGCS_ti:1: EE501_Project1/BGCS_ti/schematic, simulator spectre
    Variables: vdd = 1.6
