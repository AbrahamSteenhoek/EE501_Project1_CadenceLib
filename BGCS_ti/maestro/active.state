ADE simulation setup
Test EE501_Project1:BGCS_ti:1: EE501_Project1/BGCS_ti/schematic, simulator spectre
  Models: /remote/cadencelib/nda/ibm8rfcmos/IBM_PDK/cmrf8sf/relDM/Spectre/models/design.scs, /remote/cadencelib/nda/ibm8rfcmos/IBM_PDK/cmrf8sf/relDM/Spectre/models/allModels.scs[tt], $CDK_DIR/models/spectre/standalone/ami06N.m, $CDK_DIR/models/spectre/standalone/ami06P.m, $CDK_DIR/models/spectre/nom/ami06P.m
  Variables: vdd = 1.6
  Temperature: 27
  Simulator options: tnom=25
  Analysis dc: (saves the operating point)
Run mode: Single Run, Sweeps and Corners
